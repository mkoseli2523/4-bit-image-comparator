ADE simulation setup
Test proj_register_1: proj/register/schematic, simulator hspiceD
  Analysis tran: start=0 stop=20n step=5p
  Signals: /vdd, /clk, /clk_bar, /d, /x, /q
Run mode: Single Run, Sweeps and Corners
