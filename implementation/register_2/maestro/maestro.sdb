ADE simulation setup
Run mode: Single Run, Sweeps and Corners
Tests:
  proj_register_1: proj/register/schematic, simulator hspiceD
